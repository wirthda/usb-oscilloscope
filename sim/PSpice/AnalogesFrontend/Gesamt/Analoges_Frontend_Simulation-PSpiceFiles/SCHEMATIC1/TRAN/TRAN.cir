** Profile: "SCHEMATIC1-TRAN"  [ C:\dev\Projekt\PSpice\AnalogesFrontend\Gesamt\analoges_frontend_simulation-pspicefiles\schematic1\tran.sim ]

** Creating circuit file "TRAN.cir"
** WARNING: THIS AUTOMATICALLY GENERATED FILE MAY BE OVERWRITTEN BY SUBSEQUENT SIMULATIONS

*Libraries:
* Profile Libraries :
* Local Libraries :
.LIB "C:/dev/Projekt/PSpice/LIB/ths4631_b.lib"
* From [PSPICE NETLIST] section of C:\Users\samue\AppData\Roaming\SPB_Data\cdssetup\OrCAD_PSpice\25.1.0\PSpice.ini file:
.lib "nom.lib"

*Analysis directives:
.TRAN  0 2us 0 10ns
.OPTIONS ADVCONV
.PROBE64 V(alias(*)) I(alias(*)) W(alias(*)) D(alias(*)) NOISE(alias(*))
.INC "..\SCHEMATIC1.net"

.END
