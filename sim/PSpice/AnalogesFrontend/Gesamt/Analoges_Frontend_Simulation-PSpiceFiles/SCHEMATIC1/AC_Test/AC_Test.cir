** Profile: "SCHEMATIC1-AC_Test"  [ C:\dev\Projekt\PSpice\AnalogesFrontend\Gesamt\Analoges_Frontend_Simulation-PSpiceFiles\SCHEMATIC1\AC_Test.sim ]

** Creating circuit file "AC_Test.cir"
** WARNING: THIS AUTOMATICALLY GENERATED FILE MAY BE OVERWRITTEN BY SUBSEQUENT SIMULATIONS

*Libraries:
* Profile Libraries :
* Local Libraries :
.LIB "C:/dev/Projekt/PSpice/LIB/ths4631_b.lib"
* From [PSPICE NETLIST] section of C:\Users\Z003SP7U\AppData\Roaming\SPB_Data\cdssetup\OrCAD_PSpice\24.1.0\PSpice.ini file:
.lib "nom.lib"

*Analysis directives:
.AC DEC 10 100 10000
.OPTIONS ADVCONV
.PROBE64 V(alias(*)) I(alias(*)) W(alias(*)) D(alias(*)) NOISE(alias(*))
.INC "..\SCHEMATIC1.net"

.END
