** Profile: "SCHEMATIC1-AC-Ckomp"  [ C:\dev\Projekt\PSpice\AnalogesFrontend\Gesamt\analoges_frontend_simulation-pspicefiles\schematic1\ac-ckomp.sim ]

** Creating circuit file "AC-Ckomp.cir"
** WARNING: THIS AUTOMATICALLY GENERATED FILE MAY BE OVERWRITTEN BY SUBSEQUENT SIMULATIONS

*Libraries:
* Profile Libraries :
* Local Libraries :
.LIB "C:/dev/Projekt/PSpice/LIB/ths4631_b.lib"
* From [PSPICE NETLIST] section of C:\Users\samue\AppData\Roaming\SPB_Data\cdssetup\OrCAD_PSpice\25.1.0\PSpice.ini file:
.lib "nom.lib"

*Analysis directives:
.AC DEC 50 10k 10meg
.STEP PARAM Ckomp LIST 4p 5p 5.2p 5.4p 5.6p 7p
.OPTIONS ADVCONV
.PROBE64 V(alias(*)) I(alias(*)) W(alias(*)) D(alias(*)) NOISE(alias(*))
.INC "..\SCHEMATIC1.net"

.END
