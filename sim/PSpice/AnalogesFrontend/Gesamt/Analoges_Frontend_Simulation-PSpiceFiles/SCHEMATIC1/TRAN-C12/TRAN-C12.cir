** Profile: "SCHEMATIC1-TRAN-C12"  [ C:\dev\Projekt\PSpice\AnalogesFrontend\Gesamt\Analoges_Frontend_Simulation-PSpiceFiles\SCHEMATIC1\TRAN-C12.sim ]

** Creating circuit file "TRAN-C12.cir"
** WARNING: THIS AUTOMATICALLY GENERATED FILE MAY BE OVERWRITTEN BY SUBSEQUENT SIMULATIONS

*Libraries:
* Profile Libraries :
* Local Libraries :
.LIB "C:/dev/Projekt/PSpice/LIB/ths4631_b.lib"
* From [PSPICE NETLIST] section of C:\Users\samue\AppData\Roaming\SPB_Data\cdssetup\OrCAD_PSpice\25.1.0\PSpice.ini file:
.lib "nom.lib"

*Analysis directives:
.TRAN  0 20us 0 100ns
.OPTIONS ADVCONV
.PROBE64 V(alias(*)) I(alias(*)) W(alias(*)) D(alias(*)) NOISE(alias(*))
.INC "..\SCHEMATIC1.net"

.END
